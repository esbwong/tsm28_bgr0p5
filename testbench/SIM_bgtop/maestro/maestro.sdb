ADE simulation setup
Run mode: Single Run, Sweeps and Corners
Tests:
  edtest00_SIM_bgtop_1: edtest00/SIM_bgtop/schematic, simulator spectre
    Variables: vdda = 1.8
Specs:
  edtest00_SIM_bgtop_1 / GM: > 10
  edtest00_SIM_bgtop_1 / PM: > 50
  edtest00_SIM_bgtop_1 / UGF: > 1e6
  edtest00_SIM_bgtop_1 / DCG: > 40
