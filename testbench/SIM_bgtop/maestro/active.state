ADE simulation setup
Test edtest00_SIM_bgtop_1: edtest00/SIM_bgtop/schematic, simulator spectre
  Models: /afs/ee.ust.hk/sun4x_56/usr/eelocal/tsmc_icdc/tsmc028/28HPCplus_RF/PDK/TSMC_iPDK/tn28crsp029w1_1_8_2p2a/SkillPc_RF_0p9_1p8_1P9M_6X1Z1U_UT_AlRDL_ind1z1u/tsmcN28/../models/spectre/toplevel.scs[TOP_TT]
  Variables: vdda = 1.8
  Temperature: 27
  Analysis tran: stop=2.2e-3 errpreset=conservative
  Output Loop Gain Phase = phaseDegUnwrapped(getData("loopGain" ?result "stb"))
  Output Loop Gain dB20 = db(mag(getData("loopGain" ?result "stb")))
  Output PM = getData("/phaseMargin" ?result "stb_margin")
  Output UGF = getData("/phaseMarginFreq" ?result "stb_margin")
  Output GM = getData("/gainMargin" ?result "stb_margin")
  Output GMF = getData("/gainMarginFreq" ?result "stb_margin")
  Output dB20(mag(v("/vref" ?result "ac")))
  Output DCG = ymax(db(mag(getData("loopGain" ?result "stb"))))
  Signals: /pdn, /bgrdy, /vref, /Ibg/vdda (terminal)
Run mode: Single Run, Sweeps and Corners
Specs:
  edtest00_SIM_bgtop_1 / GM: > 10
  edtest00_SIM_bgtop_1 / PM: > 50
  edtest00_SIM_bgtop_1 / UGF: > 1e6
  edtest00_SIM_bgtop_1 / DCG: > 40
